| Philips Semiconductors Inc.
| Logic Products Group
| IBIS model of 74HEF4051B
| 8-CHANNEL ANALOG MULTIPLEXER/DEMULTIPLEXER
|[Packages]:
|[Package1]: SO 16-pin (T) Package ;
|[Package2]: SSOP 16-Pin (TS) Packages ;
|[Package3]: TSSOP 16-pin (TT) Package ;
[IBIS Ver]   3.2
[File Name]   hef4051b.ibs
[File Rev]   1.0
[Date]   20-Nov-2006
[Source]   File created from simulations and measurements
   (ctrlin clamp curves) by LPG Philips Semiconductors Nijmegen
[Notes]   V1.0   Ibis model.
| Revision History
| Version Date   Author/ Description
|   Editor
| 1.0   November 2006 RRV   Initial Version
[Disclaimer]
    (C) Copyright 2006 Philips Semiconductors
    All rights reserved
    Philips Semiconductors warrants and represents that the IBIS model
    identified herein is owned by Philips Semiconductors (PHILIPS). The
    model provided is not warranted as fully representing all of the
    operating characteristics and specifications of the semiconductor
    products to which the model relates.  Moreover, unless there is a
    signed, written agreement to the contrary, this IBIS model is
    furnished on an "as is" basis without support or warranty of any
    kind, either expressed or implied, regarding the use thereof, and
    PHILIPS specifically disclaims all implied warranties of
    merchantability and fitness of the model for any purpose.
    PHILIPS does not assume any liability arising out of the application
    or use of this IBIS model including infringement of patents and
    copyrights, nor does PHILIPS convey any license under its patents and
    copyrights or the rights of others.
    PHILIPS provides IBIS models as a service to our customers. You and
    your company shall not distribute, convey, sell, or give these models
    to anyone else without receiving prior written permission from
    PHILIPS.
    PHILIPS reserves the right to make changes without notice to these
    IBIS models to improve reliability, function, or design.
    Please be aware that your receipt and subsequent use of the IBIS
    information provided shall serve as acceptance of the terms and
    conditions of this agreement.  If you do not accept these terms,
    you should return or destroy the IBIS models and any other
    accompanying information immediately.
|   Info for  SO 16-pin (T) Package
[Component]   74HEF4051B_T
[Manufacturer]   Philips Semiconductors Inc.
[Package]
|   typ   min   max
R_pkg   1.75E-01   1.28E-01   2.11E-01
L_pkg   5.03E-09   3.94E-09   6.26E-09
C_pkg   0.794E-12  0.715E-12  0.869E-12
[Pin] signal_name   model_name   R_pin   L_pin   C_pin
   1   Y4   hef_switchzyion 1.99E-01  6.26E-09 0.822E-12
   2   Y6   hef_switchzyion 2.11E-01  5.46E-09 0.869E-12
   3   Z   hef_switchyzion 1.56E-01  4.44E-09 0.760E-12
   4   Y7   hef_switchzyion 1.28E-01  3.94E-09 0.717E-12
   5   Y5   hef_switchzyion 1.28E-01  3.94E-09 0.715E-12
   6   En   hef_ctrlin 1.56E-01  4.44E-09 0.760E-12
   7   VEE   GND 2.11E-01  5.46E-09 0.869E-12
   8   GND   GND 1.99E-01  6.26E-09 0.843E-12
   9   A2   hef_ctrlin 1.99E-01  6.26E-09 0.843E-12
   10   A1   hef_ctrlin 2.11E-01  5.46E-09 0.869E-12
   11   A0   hef_ctrlin 1.56E-01  4.44E-09 0.760E-12
   12   Y3   hef_switchzyion 1.28E-01  3.94E-09 0.717E-12
   13   Y0   hef_switchzyion 1.28E-01  3.94E-09 0.715E-12
   14   Y1   hef_switchzyion 1.56E-01  4.44E-09 0.760E-12
   15   Y2   hef_switchzyion 2.11E-01  5.46E-09 0.869E-12
   16   VCC   POWER 1.99E-01  6.26E-09 0.843E-12
|   Info for  SSOP 16-Pin (TS) Packages
[Component]   74HEF4051B_TS
[Manufacturer]   Philips Semiconductors Inc.
[Package]
|   typ   min   max
R_pkg   49.80E-03   39.40E-03   59.80E-03
L_pkg   2.52E-09   1.87E-09   3.16E-09
C_pkg   0.48E-12   0.40E-12   0.57E-12
[Pin] signal_name   model_name   R_pin   L_pin   C_pin
   1   Y4   hef_switchzyion 59.80E-03  3.16E-09  0.47E-12
   2   Y6   hef_switchzyion 45.50E-03  2.41E-09  0.53E-12
   3   Z   hef_switchyzion 46.40E-03  1.93E-09  0.43E-12
   4   Y7   hef_switchzyion 39.40E-03  1.87E-09  0.43E-12
   5   Y5   hef_switchzyion 39.40E-03  1.87E-09  0.41E-12
   6   En   hef_ctrlin 46.40E-03  1.93E-09  0.40E-12
   7   VEE   GND 45.50E-03  2.41E-09  0.48E-12
   8   GND   GND 59.80E-03  3.16E-09  0.57E-12
   9   A2   hef_ctrlin 59.80E-03  3.16E-09  0.47E-12
   10   A1   hef_ctrlin 45.50E-03  2.41E-09  0.53E-12
   11   A0   hef_ctrlin 46.40E-03  1.93E-09  0.43E-12
   12   Y3   hef_switchzyion 39.40E-03  1.87E-09  0.43E-12
   13   Y0   hef_switchzyion 39.40E-03  1.87E-09  0.41E-12
   14   Y1   hef_switchzyion 46.40E-03  1.93E-09  0.40E-12
   15   Y2   hef_switchzyion 45.50E-03  2.41E-09  0.48E-12
   16   VCC   POWER 59.80E-03  3.16E-09  0.57E-12
|   Info for  TSSOP 16-pin (TT) Package
[Component]   74HEF4051B_TT
[Manufacturer]   Philips Semiconductors Inc.
[Package]
|   typ   min   max
R_pkg   3.95E-02   3.52E-02   4.56E-02
L_pkg   1.94E-09   1.65E-09   2.40E-09
C_pkg   0.446E-12  0.335E-12  0.771E-12
[Pin] signal_name   model_name   R_pin   L_pin   C_pin
   1   Y4   hef_switchzyion 3.52E-02  2.40E-09 0.436E-12
   2   Y6   hef_switchzyion 3.70E-02  1.93E-09 0.438E-12
   3   Z   hef_switchyzion 4.56E-02  1.76E-09 0.345E-12
   4   Y7   hef_switchzyion 4.00E-02  1.65E-09 0.335E-12
   5   Y5   hef_switchzyion 4.00E-02  1.65E-09 0.335E-12
   6   En   hef_ctrlin 4.56E-02  1.76E-09 0.345E-12
   7   VEE   GND 3.70E-02  1.93E-09 0.438E-12
   8   GND   GND 3.52E-02  2.40E-09 0.452E-12
   9   A2   hef_ctrlin 3.52E-02  2.40E-09 0.452E-12
   10   A1   hef_ctrlin 3.70E-02  1.93E-09 0.438E-12
   11   A0   hef_ctrlin 4.56E-02  1.76E-09 0.345E-12
   12   Y3   hef_switchzyion 4.00E-02  1.65E-09 0.771E-12
   13   Y0   hef_switchzyion 4.00E-02  1.65E-09 0.771E-12
   14   Y1   hef_switchzyion 4.56E-02  1.76E-09 0.345E-12
   15   Y2   hef_switchzyion 3.70E-02  1.93E-09 0.438E-12
   16   VCC   POWER 3.52E-02  2.40E-09 0.452E-12
[Series Pin Mapping]  pin_2  model_name   function_table_group
 1   3   hef_switchyz   1
 2   3   hef_switchyz   2
 4   3   hef_switchyz   3
 5   3   hef_switchyz   4
12   3   hef_switchyz   5
13   3   hef_switchyz   6
14   3   hef_switchyz   7
15   3   hef_switchyz   8
 3   1   hef_switchzy   9
 3   2   hef_switchzy   10
 3   4   hef_switchzy   11
 3   5   hef_switchzy   12
 3   12   hef_switchzy   13
 3   13   hef_switchzy   14
 3   14   hef_switchzy   15
 3   15   hef_switchzy   16
[Series Switch Groups]
| Function Group States
On  1 /   | Y4->Z E LOW
On  2 /   | Y6->Z E LOW
On  3 /   | Y7->Z E LOW
On  4 /   | Y5->Z E LOW
On  5 /   | Y3->Z E LOW
On  6 /   | Y0->Z E LOW
On  7 /   | Y1->Z E LOW
On  8 /   | Y2->Z E LOW
On  9 /   | Z->Y4 E LOW
On 10 /   | Z->Y6 E LOW
On 11 /   | Z->Y7 E LOW
On 12 /   | Z->Y5 E LOW
On 13 /   | Z->Y3 E LOW
On 14 /   | Z->Y0 E LOW
On 15 /   | Z->Y1 E LOW
On 16 /   | Z->Y2 E LOW
| End Function Group States
| Remark: If your software does not support the Model Selector
|   Please comment out the lines of the Model Selector, which
|   contain the name of the Model, except the one you want to use.
| Model hef_switchyz (part of model hef_switchyzion)
[Model Selector]   hef_switchyz
HEF_SWITCHYZ_05   5.0V Vcc Series switch model
HEF_SWITCHYZ_10   10.0V Vcc Series switch model
HEF_SWITCHYZ_15   15.0V Vcc Series switch model
| Model hef_switchzy (part of model hef_switchzyion)
[Model Selector]   hef_switchzy
HEF_SWITCHZY_05   5.0V Vcc Series switch model
HEF_SWITCHZY_10   10.0V Vcc Series switch model
HEF_SWITCHZY_15   15.0V Vcc Series switch model
[Model Selector]   hef_switchzyion
HEF_SWITCHZYION_15   15.0V Vcc bilateral switch model
HEF_SWITCHZYION_10   10.0V Vcc bilateral switch model
HEF_SWITCHZYION_05   5.0V Vcc bilateral switch model
[Model Selector]   hef_switchyzion
HEF_SWITCHYZION_15   15.0V Vcc bilateral switch model
HEF_SWITCHYZION_10   10.0V Vcc bilateral switch model
HEF_SWITCHYZION_05   5.0V Vcc bilateral switch model
[Model Selector]   hef_ctrlin
HEF_CTRLIN_15   15.0V Vcc input model
HEF_CTRLIN_10   10.0V Vcc input model
HEF_CTRLIN_05   5.0V Vcc input model
|   Model HEF_SWITCHZY_15
[Model]   HEF_SWITCHZY_15
Model_type Series_switch
C_comp   3.36E-12   3.01E-12   3.74E-12
|Ambient temperature: 25   85   -40
[Temperature Range]   35   95   -30
[Voltage Range]   15V   15V   15V
[Off]
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[On]
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|   Model HEF_SWITCHZY_10
[Model]   HEF_SWITCHZY_10
Model_type Series_switch
C_comp   3.36E-12   3.04E-12   3.72E-12
|Ambient temperature: 25   85   -40
[Temperature Range]   35   95   -30
[Voltage Range]   10V   10V   10V
[Off]
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[On]
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|   Model HEF_SWITCHZY_05
[Model]   HEF_SWITCHZY_05
Model_type Series_switch
C_comp   3.43E-12   3.07E-12   3.72E-12
|Ambient temperature: 25   85   -40
[Temperature Range]   35   95   -30
[Voltage Range]   5V   5V   5V
[Off]
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[On]
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|   Model HEF_SWITCHYZ_15
[Model]   HEF_SWITCHYZ_15
Model_type Series_switch
C_comp   19.4E-12   17.2E-12   21.4E-12
|Ambient temperature: 25   85   -40
[Temperature Range]   35   95   -30
[Voltage Range]   15V   15V   15V
[Off]
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[On]
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|   Model HEF_SWITCHYZ_10
[Model]   HEF_SWITCHYZ_10
Model_type Series_switch
C_comp   19.4E-12   17.7E-12   21.6E-12
|Ambient temperature: 25   85   -40
[Temperature Range]   35   95   -30
[Voltage Range]   10V   10V   10V
[Off]
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[On]
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|   Model HEF_SWITCHYZ_05
[Model]   HEF_SWITCHYZ_05
Model_type Series_switch
C_comp   20.1E-12   18.1E-12   21.9E-12
|Ambient temperature: 25   85   -40
[Temperature Range]   35   95   -30
[Voltage Range]   5V   5V   5V
[Off]
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[On]
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| Models and submodels in the file (15): HEF_SWITCHZYION_15 (I/O), HEF_SWITCHZY_15 (Series_switch), HEF_SWITCHZYION_10 (I/O), HEF_SWITCHZY_10 (Series_switch), HEF_SWITCHZYION_05 (I/O), HEF_SWITCHZY_05 (Series_switch), HEF_SWITCHYZION_15 (I/O), HEF_SWITCHYZ_15 (Series_switch), HEF_SWITCHYZION_10 (I/O), HEF_SWITCHYZ_10 (Series_switch), HEF_SWITCHYZION_05 (I/O), HEF_SWITCHYZ_05 (Series_switch), HEF_CTRLIN_15 (Input), HEF_CTRLIN_10 (Input), HEF_CTRLIN_05 (Input)
